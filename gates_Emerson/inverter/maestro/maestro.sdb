ADE simulation setup
Run mode: Single Run, Sweeps and Corners
Tests:
  gates_Emerson_inverter_1: gates_Emerson/inverter/schematic, simulator spectre
