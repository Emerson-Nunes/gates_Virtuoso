ADE simulation setup
Test gates_Emerson_inverter_1: gates_Emerson/inverter/schematic, simulator spectre
  Models: /tools/gpdk/gpdk045_v_6_0/gpdk045/../models/spectre/gpdk045.scs[mc]
  Temperature: 27
  Stimulus in: voltage pulse val0=0 val1=1 period=2n delay=1p rise=1p fall=1p width=1n srcType=pulse
  Analysis tran: stop=2n
  Signals: /in, /out
Run mode: Single Run, Sweeps and Corners
