ADE simulation setup
Test gates_Emerson_mult_4_1_1: gates_Emerson/mult_4_1/schematic, simulator spectre
  Models: /tools/gpdk/gpdk045_v_6_0/gpdk045/../models/spectre/gpdk045.scs[mc]
  Variables: pA = 16n; pB = 8n; pC = 4n; vdd = 1; pD = 2n; pS1 = 32n; pS0 = 64n
  Temperature: 27
  Stimulus C: voltage pulse val0=1 val1=0 period=pC delay=1p rise=1p fall=1p width=pC/2 srcType=pulse
  Stimulus B: voltage pulse val0=1 val1=0 period=pB delay=1p rise=1p fall=1p width=pB/2 srcType=pulse
  Stimulus A: voltage pulse val0=1 val1=0 period=pA delay=1p rise=1p fall=1p width=pA/2 srcType=pulse
  Stimulus S0: voltage pulse val0=1 val1=0 period=(pS0) delay=1p rise=1p fall=1p width=((pS0) / 2) srcType=pulse
  Stimulus S1: voltage pulse val0=1 val1=0 period=(pS1) delay=1p rise=1p fall=1p width=((pS1) / 2) srcType=pulse
  Stimulus D: voltage pulse val0=1 val1=0 period=pD delay=1p rise=1p fall=1p width=pD/2 srcType=pulse
  Analysis tran: stop=VAR("pS0")
  Signals: /S0, /S1, /A, /B, /C, /D, /Y
Run mode: Single Run, Sweeps and Corners
