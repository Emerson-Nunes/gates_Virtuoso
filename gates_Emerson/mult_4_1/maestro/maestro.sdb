ADE simulation setup
Run mode: Single Run, Sweeps and Corners
Tests:
  gates_Emerson_mult_4_1_1: gates_Emerson/mult_4_1/schematic, simulator spectre
    Variables: pA = 16n; pB = 8n; pC = 4n; vdd = 1; pD = 2n; pS1 = 32n; pS0 = 64n
