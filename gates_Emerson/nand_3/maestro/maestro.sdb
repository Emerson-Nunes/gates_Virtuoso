ADE simulation setup
Run mode: Single Run, Sweeps and Corners
Tests:
  gates_Emerson_nand_3_1: gates_Emerson/nand_3/schematic, simulator spectre
    Variables: pC = 2; pA = 8; pB = 4; vdd = 1
