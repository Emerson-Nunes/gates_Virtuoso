ADE simulation setup
Test gates_Emerson_nand_3_1: gates_Emerson/nand_3/schematic, simulator spectre
  Models: /tools/gpdk/gpdk045_v_6_0/gpdk045/../models/spectre/gpdk045.scs[mc]
  Variables: pC = 2; pA = 8; pB = 4; vdd = 1
  Temperature: 27
  Stimulus A: voltage pulse val0=1 val1=0 period=pA*1n delay=1p rise=1p fall=1p width=((pA / 2) * 1e-09) srcType=pulse
  Stimulus B: voltage pulse val0=1 val1=0 period=pB*1n delay=1p rise=1p fall=1p width=((pB / 2) * 1e-09) srcType=pulse
  Stimulus C: voltage pulse val0=1 val1=0 period=pC*1n delay=1p rise=1p fall=1p width=((pC / 2) * 1e-09) srcType=pulse
  Analysis tran: stop=VAR("pA")*1n
  Signals: /A, /B, /C, /Y
Run mode: Single Run, Sweeps and Corners
