ADE simulation setup
Run mode: Single Run, Sweeps and Corners
Tests:
  gates_Emerson_and_3_1: gates_Emerson/and_3/schematic, simulator spectre
    Variables: pA = 8n; pB = 4n; pC = 2n; vdd = 1
