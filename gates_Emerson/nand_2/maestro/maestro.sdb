ADE simulation setup
Run mode: Single Run, Sweeps and Corners
Tests:
  gates_Emerson_nand_2_1: gates_Emerson/nand_2/schematic, simulator spectre
