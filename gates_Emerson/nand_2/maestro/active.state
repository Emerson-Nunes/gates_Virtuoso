ADE simulation setup
Test gates_Emerson_nand_2_1: gates_Emerson/nand_2/schematic, simulator spectre
  Models: /tools/gpdk/gpdk045_v_6_0/gpdk045/../models/spectre/gpdk045.scs[mc]
  Temperature: 27
  Stimulus A: voltage pulse val0=0 val1=1 period=8n delay=1p rise=1p fall=1p width=4n srcType=pulse
  Stimulus B: voltage pulse val0=0 val1=1 period=4n delay=1p rise=1p fall=1p width=2n srcType=pulse
  Analysis tran: stop=8n
  Signals: /A, /B, /Y
Run mode: Single Run, Sweeps and Corners
