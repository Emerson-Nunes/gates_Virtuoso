ADE simulation setup
Test gates_Emerson_teste_inverter_1: gates_Emerson/teste_inverter/schematic, simulator spectre
  Models: /tools/gpdk/gpdk045_v_6_0/gpdk045/../models/spectre/gpdk045.scs[mc]
  Temperature: 27
  Analysis tran: stop=2n
  Signals: /out, /teste
Run mode: Single Run, Sweeps and Corners
