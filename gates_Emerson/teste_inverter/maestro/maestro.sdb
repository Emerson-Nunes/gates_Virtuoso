ADE simulation setup
Run mode: Single Run, Sweeps and Corners
Tests:
  gates_Emerson_teste_inverter_1: gates_Emerson/teste_inverter/schematic, simulator spectre
    Outputs: /in; /out
