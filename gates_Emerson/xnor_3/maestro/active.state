ADE simulation setup
Test gates_Emerson_xnor_3_1: gates_Emerson/xnor_3/schematic, simulator spectre
  Models: /tools/gpdk/gpdk045_v_6_0/gpdk045/../models/spectre/gpdk045.scs[mc]
  Variables: pA = 8n; pB = 4n; pC = 2n; vdd = 1
  Temperature: 27
  Stimulus A: voltage pulse val0=1 val1=0 period=pA delay=1p rise=1p fall=1p width=pA/2 srcType=pulse
  Stimulus B: voltage pulse val0=1 val1=0 period=pB delay=1p rise=1p fall=1p width=pB/2 srcType=pulse
  Stimulus C: voltage pulse val0=1 val1=0 period=pC delay=1p rise=1p fall=1p width=pC/2 srcType=pulse
  Analysis tran: stop=VAR("pA")
  Signals: /A, /B, /C, /Y
Run mode: Single Run, Sweeps and Corners
